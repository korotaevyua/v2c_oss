* Generated by v2c 0.0.0
* Source: in.v
* Top:    top
* Flavor: calibre

.INCLUDE "lib.cdl"

.SUBCKT top mode<1> mode<0> en q<1> q<0> VDD VSS
*.PININFO mode<1>:I mode<0>:I en:I q<1>:O q<0>:O VDD:B VSS:B
Xu_inv0 mode<0> mode_n<0> VDD VSS INV
Xu_inv1 mode<1> mode_n<1> VDD VSS INV
Xu_ctl en mode_n<1> mode_n<0> q<1> q<0> VDD VSS MODECTL
.ENDS top
