* Synthetic cell library for golden tests. Not from any PDK.

.SUBCKT INV A Y VDD VSS
*.PININFO A:I Y:O VDD:P VSS:G
MP0 Y A VDD VDD pch W=1.0u L=0.1u
MN0 Y A VSS VSS nch W=0.5u L=0.1u
.ENDS INV

.SUBCKT NAND2 A B Y VDD VSS
*.PININFO A:I B:I Y:O VDD:P VSS:G
MP0 Y A VDD VDD pch W=1.0u L=0.1u
MP1 Y B VDD VDD pch W=1.0u L=0.1u
MN0 Y A n0 VSS nch W=1.0u L=0.1u
MN1 n0 B VSS VSS nch W=1.0u L=0.1u
.ENDS NAND2

* Synthetic macro with bus pins, spelled the CDL way.
.SUBCKT MODECTL EN SEL<1> SEL<0> Q<1> Q<0> VDD VSS
*.PININFO EN:I SEL<1>:I SEL<0>:I Q<1>:O Q<0>:O VDD:P VSS:G
* Body omitted: the converter reads headers only.
.ENDS MODECTL
