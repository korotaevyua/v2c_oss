* Generated by v2c 0.0.0
* Source: in.v
* Top:    cg
* Flavor: calibre

.INCLUDE "lib.cdl"

.SUBCKT cg CK E SE ECK VDD VSS VNWB VPWB
*.PININFO CK:I E:I SE:I ECK:O VDD:B VSS:B VNWB:B VPWB:B
Xu_buf E e_buf VDD VNWB VPWB VSS BUFX
Xu_tie tie_lo VDD VDD VSS VSS TIELO
Xu_cg CK e_buf tie_lo ECK VDD VDD VSS VSS CKGATE
.ENDS cg
