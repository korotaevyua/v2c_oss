* Generated by v2c 0.0.0
* Source: in.v
* Top:    top
* Flavor: calibre

.INCLUDE "lib.cdl"

.SUBCKT and2 a b y VDD VSS
*.PININFO a:I b:I y:O VDD:B VSS:B
Xg0 a b n VDD VSS NAND2
Xg1 n y VDD VSS INV
.ENDS and2

.SUBCKT top a b c y VDD VSS
*.PININFO a:I b:I c:I y:O VDD:B VSS:B
Xu_and0 a b ab VDD VSS and2
Xu_and1 ab c y VDD VSS and2
.ENDS top
