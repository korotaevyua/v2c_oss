* Generated by v2c 0.0.0
* Source: in.v
* Top:    top
* Flavor: calibre

.SUBCKT top a y VDD VSS
*.PININFO a:I y:O VDD:B VSS:B
Xu0 a y VDD VSS INV
.ENDS top
