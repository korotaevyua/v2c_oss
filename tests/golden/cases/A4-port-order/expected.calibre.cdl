* Generated by v2c 0.0.0
* Source: in.v
* Top:    top
* Flavor: calibre

.SUBCKT top y VSS b VDD a
*.PININFO y:O VSS:B b:I VDD:B a:I
Xu0 a b y VDD VSS NAND2
.ENDS top
