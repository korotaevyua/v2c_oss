* Generated by v2c 0.0.0
* Source: in.v
* Top:    top
* Flavor: calibre

.INCLUDE "lib.cdl"

.SUBCKT pair a<1> a<0> y VDD VSS
*.PININFO a<1>:I a<0>:I y:O VDD:B VSS:B
Xg a<1> a<0> y VDD VSS NAND2
.ENDS pair

.SUBCKT top d<7> d<6> d<5> d<4> y VDD VSS
*.PININFO d<7>:I d<6>:I d<5>:I d<4>:I y:O VDD:B VSS:B
Xu d<6> d<5> y VDD VSS pair
.ENDS top
