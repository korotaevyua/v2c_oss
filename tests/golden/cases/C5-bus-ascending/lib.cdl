* Synthetic cell library for golden tests. Not from any PDK.

.SUBCKT AND3 I<2> I<1> I<0> Y VDD VSS
*.PININFO I<2>:I I<1>:I I<0>:I Y:O VDD:P VSS:G
* Body omitted: the converter reads headers only.
.ENDS AND3
