* Generated by v2c 0.0.0
* Source: in.v
* Top:    top
* Flavor: calibre

.INCLUDE "lib.cdl"

.SUBCKT top a<0> a<1> a<2> y VDD VSS
*.PININFO a<0>:I a<1>:I a<2>:I y:O VDD:B VSS:B
Xu a<0> a<1> a<2> y VDD VSS AND3
.ENDS top
