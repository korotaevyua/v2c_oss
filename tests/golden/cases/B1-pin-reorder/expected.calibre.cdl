* Generated by v2c 0.0.0
* Source: in.v
* Top:    top
* Flavor: calibre

.SUBCKT top d en clk rst_n q VDD VSS
*.PININFO d:I en:I clk:I rst_n:I q:O VDD:B VSS:B
Xu_mux d en q_int dn VDD VSS AOI21
Xu_reg dn clk rst_n q_int q_bar VDD VSS DFFR
Xu_out q_bar q VDD VSS INV
.ENDS top
