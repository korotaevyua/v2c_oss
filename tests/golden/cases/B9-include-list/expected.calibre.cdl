* Generated by v2c 0.0.0
* Source: in.v
* Top:    top
* Flavor: calibre

.INCLUDE "lib.cdl"

.SUBCKT top clk en d q VDD VSS
*.PININFO clk:I en:I d:I q:O VDD:B VSS:B
Xu_inv en en_n VDD VSS INV
Xu_macro clk en_n d dout VDD VSS HARDMACRO
Xu_out dout en q VDD VSS NAND2
.ENDS top
