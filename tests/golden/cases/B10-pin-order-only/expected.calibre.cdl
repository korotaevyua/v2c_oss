* Generated by v2c 0.0.0
* Source: in.v
* Top:    top
* Flavor: calibre

.INCLUDE "lib.cdl"

.SUBCKT top a y VDD VSS
*.PININFO a:I y:O VDD:B VSS:B
Xu_inv a a_n VDD VSS INV
Xu_macro a a a_n y VDD VSS HARDMACRO
.ENDS top
