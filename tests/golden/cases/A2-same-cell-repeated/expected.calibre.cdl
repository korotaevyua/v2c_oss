* Generated by v2c 0.0.0
* Source: in.v
* Top:    top
* Flavor: calibre

.SUBCKT top a y VDD VSS
*.PININFO a:I y:O VDD:B VSS:B
Xu1 a n1 VDD VSS INV
Xu2 n1 n2 VDD VSS INV
Xu3 n2 n3 VDD VSS INV
Xu4 n3 y VDD VSS INV
.ENDS top
